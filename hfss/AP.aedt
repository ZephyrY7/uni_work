# Ansys Electronics Desktop project, version 2022.1
materials:
  vacuum: permittivity=1
  copper: permeability=0.999991 conductivity=58000000
  FR4_epoxy: permittivity=4.4 dielectric_loss_tangent=0.02
  air: permittivity=1.0006 permeability=1.0000004

design HFSSDesign1 (HFSS, DrivenTerminal, model units mm)
geometry:
  Ground [copper] = box(corner=((-40.0112/2) mm, (-52.8/2) mm, -0.04mm), size=(40.0112mm, 52.8mm, 0.04mm))
  Substrate [FR4_epoxy] = box(corner=(-20.0056mm, -26.4mm, 0mm), size=(40.0112mm, 52.8mm, 1.62mm))
  Patch = box(corner=((-35/2) mm, (-43.5/2) mm, 1.62mm), size=(33.5mm, 43.5mm, 0.04mm))
  Feedline [copper] = box(corner=(14.8056mm, (-2.7/2) mm, 1.62mm), size=(5.2mm, 2.7mm, 0.04mm))
  Feedline.unite(Patch)
  Environment [air] = box(corner=((-60.0168/2) mm, (-79.2/2) mm, (-60/2) mm), size=(60.0168mm, 79.2mm, 60mm))
  Box1 = box(corner=(8.35mm, -6mm, 1.62mm), size=(7.65mm, 4mm, 0.04mm))
  Box2 = box(corner=(8.35mm, 2mm, 1.62mm), size=(7.65mm, 4mm, 0.04mm))
  Feedline.subtract(Box1, Box2)
  Feedline_ObjectFromEdge1 [copper] = object_from(Feedline.edge(1 of 12))
  Feedline_ObjectFromEdge1.sweep_along_vector((0mm, 0mm, -1.7mm))
boundaries and excitations:
  PerfE1: Perfect E Objects=[Feedline, Ground]
  Rad1: Radiation Objects=Environment
  Feedline_T1: Terminal port=1 Edges=Feedline.edge(10 of 12, 5 of 12, 12 of 12, 1 of 12) TerminalResistance=50ohm
  1: Lumped Port Faces=Feedline_ObjectFromEdge1.face Impedance=50ohm
  reference conductors: Ground
setups:
  Test1: HfssDriven Frequency=2.1GHz MaxDeltaS=0.02 MaximumPasses=20 MinimumPasses=1 MinimumConvergedPasses=1 PercentRefinement=30 BasisOrder=1 PortAccuracy=2 DrivenSolverType="Direct Solver"
    sweep Sweep: 1.65GHz to 2.5GHz step 0.00525GHz; Type=Fast SaveFields
source amplitudes:
  1:1: 1V 0deg
radiation setups:
  Infinite Sphere1: Infinite Sphere Theta=0deg..180deg step 10deg Phi=0deg..360deg step 10deg
reports:
  Terminal S Parameter Plot 1: dB(St(Feedline_T1,Feedline_T1)) vs Freq on Test1 : Sweep; markers m1 at 2.10675GHz, m2 at 2.05425GHz, m3 at 2.15925GHz
  Terminal VSWR Plot 1: VSWRt(Feedline_T1) vs Freq on Test1 : Sweep; markers m1 at 2.10675GHz
  Gain Plot 1: GainTotal vs Phi, Theta on Test1 : LastAdaptive, Infinite Sphere1 [Freq=2.1GHz]
  rE Plot 1: rETotal vs Phi, Theta on Test1 : LastAdaptive, Infinite Sphere1 [Freq=2.1GHz]
  Directivity Plot 1: DirTotal vs Phi, Theta on Test1 : LastAdaptive, Infinite Sphere1 [Freq=2.1GHz]
